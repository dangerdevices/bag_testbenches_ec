ADE simulation setup
Run mode: Single Run, Sweeps and Corners
Tests:
  tb_noise: bag_testbenches_ec/mos_tb_noise/schematic, simulator spectre
    Outputs: idn
Global variables:
  vb_dc = 0
  vbs = 0
  vds = 0.4
  vgs = 0.4
  freq_start = 10
  freq_stop = 10M
  num_per_dec = 50
