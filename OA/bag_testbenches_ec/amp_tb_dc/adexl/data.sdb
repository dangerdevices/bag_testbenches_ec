ADE simulation setup
Run mode: Single Run, Sweeps and Corners
Tests:
  tb_dc: bag_testbenches_ec/amp_tb_dc/schematic, simulator spectre
Global variables:
  gain_fb = -200
  ibias = 100u
  vdd = 1
  vout_start = 0.1
  vout_stop = 1
  vout_num = 100
  voutref = 0.5
  vimax = 0
  vimin = 1
