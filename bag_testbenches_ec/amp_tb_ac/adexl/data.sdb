ADE simulation setup
Run mode: Single Run, Sweeps and Corners
Tests:
  tb_ac: bag_testbenches_ec/amp_tb_ac/schematic, simulator spectre
Global variables:
  ibias = 100u
  vdd = 1
  vinac = 1
  vindc = 0.5
  fstart = 1M
  fstop = 10e9
  fndec = 20
  cload = 10f
