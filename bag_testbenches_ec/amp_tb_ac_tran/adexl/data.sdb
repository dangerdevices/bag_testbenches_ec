ADE simulation setup
Run mode: Single Run, Sweeps and Corners
Tests:
  tb_ac_tran: bag_testbenches_ec/amp_tb_ac_tran/schematic, simulator spectre
Global variables:
  ibias = 100u
  vdd = 1
  vinac = 1
  vindc = 0.5
  fstart = 1M
  fstop = 10e9
  fndec = 20
  tsim = 1n
  tstep = 1p
  cload = 10f
