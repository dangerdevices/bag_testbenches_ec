ADE simulation setup
Run mode: Single Run, Sweeps and Corners
Tests:
  tb_tran: bag_testbenches_ec/amp_tb_tran/schematic, simulator spectre
