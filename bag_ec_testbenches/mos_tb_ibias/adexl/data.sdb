ADE simulation setup
Run mode: Single Run, Sweeps and Corners
Tests:
  tb_dc: bag_ec_testbenches/mos_tb_ibias/schematic, simulator spectre
Global variables:
  vgs = 0.5
  vs = 0
  vgs_start = 0
  vgs_stop = 0
  vgs_num = 10
