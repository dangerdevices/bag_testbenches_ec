ADE simulation setup
Run mode: Single Run, Sweeps and Corners
Tests:
  tb_sp: bag_ec_testbenches/mos_tb_sp/schematic, simulator spectre
    Outputs: y11; y13; y12; y21; y22; y23; y31; y32; y33
Global variables:
  vb_dc = 0
  vbs = 0.5
  vds = 0.5
  vgs = 0.5
  sp_freq = 100
  vgs_start = 0.2
  vgs_stop = 0.5
  vgs_num = 10
